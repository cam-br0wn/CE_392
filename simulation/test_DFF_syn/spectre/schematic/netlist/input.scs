// Design: sobel_operator/test_DFF_syn
simulator lang=spectre
global 0
parameters vdd=1.1
include "/vol/eecs391/FreePDK45/ncsu_basekit/models/hspice/hspice_nom.include"

// sobel_operator/NAND2/schematic
subckt NAND2 A B Y gnd vdd
    M2 (Y A net16 gnd) NMOS_VTG w=400n l=50n ld=105n ls=105n m=1
    M3 (net16 B gnd gnd) NMOS_VTG w=400n l=50n ld=105n ls=105n m=1
    M0 (Y A vdd vdd) PMOS_VTG w=600n l=50n ld=105n ls=105n m=1
    M1 (Y B vdd vdd) PMOS_VTG w=600n l=50n ld=105n ls=105n m=1
ends NAND2

// sobel_operator/inverter/schematic
subckt inverter A GND VDD Y
    M0 (Y A VDD VDD) PMOS_VTG w=600n l=50n ld=105n ls=105n m=1
    M1 (Y A GND GND) NMOS_VTG w=400n l=50n ld=105n ls=105n m=1
ends inverter

// sobel_operator/DFF_sync/schematic
subckt DFF_sync D Q Q_bar clk gnd vdd
    I13 (Q net15 Q_bar gnd vdd) NAND2
    I12 (net14 Q_bar Q gnd vdd) NAND2
    I11 (clk net12 net15 gnd vdd) NAND2
    I10 (D clk net14 gnd vdd) NAND2
    I14 (D gnd vdd net12) inverter
ends DFF_sync

// sobel_operator/test_DFF_syn/schematic
I0 (D Q Q_bar clk net9 net10) DFF_sync
V0 (D 0) vsource type=bit val0=0 val1=1.1 period=10n rise=10p fall=10p data="00010011000000" rptstart=1 rpttimes=0
default_config (clk 0) vsource dc=0 type=pulse val0=0 val1=1.1 period=10n delay=1n rise=20p fall=20p width=5n
V3 (net9 0) vsource dc=0 type=dc
V1 (net10 0) vsource dc=vdd type=dc
simulatorOptions options temp=27
tran tran stop=100n errpreset=moderate
save D clk Q Q_bar
