// Design: sobel_operator/test_shift_reg
simulator lang=spectre
global 0
parameters vdd=1.1
include "/vol/eecs391/FreePDK45/ncsu_basekit/models/hspice/hspice_nom.include"

// sobel_operator/NAND2/schematic
subckt NAND2 A B Y gnd vdd
    M2 (Y A net16 gnd) NMOS_VTG w=400n l=50n ld=105n ls=105n m=1
    M3 (net16 B gnd gnd) NMOS_VTG w=400n l=50n ld=105n ls=105n m=1
    M0 (Y A vdd vdd) PMOS_VTG w=600n l=50n ld=105n ls=105n m=1
    M1 (Y B vdd vdd) PMOS_VTG w=600n l=50n ld=105n ls=105n m=1
ends NAND2

// sobel_operator/inverter/schematic
subckt inverter A GND VDD Y
    M0 (Y A VDD VDD) PMOS_VTG w=600n l=50n ld=105n ls=105n m=1
    M1 (Y A GND GND) NMOS_VTG w=400n l=50n ld=105n ls=105n m=1
ends inverter

// sobel_operator/DFF_sync/schematic
subckt DFF_sync D Q Q_bar clk gnd vdd
    I11 (clk net12 net15 gnd vdd) NAND2
    I10 (D clk net14 gnd vdd) NAND2
    I13 (Q net15 Q_bar gnd vdd) NAND2
    I12 (net14 Q_bar Q gnd vdd) NAND2
    I14 (D gnd vdd net12) inverter
ends DFF_sync

// sobel_operator/8bit_reg/schematic
subckt sobel_operator_8bit_reg_schematic D\<7\> D\<6\> D\<5\> D\<4\> D\<3\> D\<2\> D\<1\> D\<0\> Q\<7\> Q\<6\> Q\<5\> Q\<4\> Q\<3\> Q\<2\> Q\<1\> Q\<0\> Q_bar\<7\> Q_bar\<6\> Q_bar\<5\> Q_bar\<4\> Q_bar\<3\> Q_bar\<2\> Q_bar\<1\> Q_bar\<0\> clk gnd vdd
    I7 (D\<7\> Q\<7\> Q_bar\<7\> clk gnd vdd) DFF_sync
    I6 (D\<6\> Q\<6\> Q_bar\<6\> clk gnd vdd) DFF_sync
    I5 (D\<5\> Q\<5\> Q_bar\<5\> clk gnd vdd) DFF_sync
    I4 (D\<4\> Q\<4\> Q_bar\<4\> clk gnd vdd) DFF_sync
    I3 (D\<3\> Q\<3\> Q_bar\<3\> clk gnd vdd) DFF_sync
    I2 (D\<2\> Q\<2\> Q_bar\<2\> clk gnd vdd) DFF_sync
    I1 (D\<1\> Q\<1\> Q_bar\<1\> clk gnd vdd) DFF_sync
    I0 (D\<0\> Q\<0\> Q_bar\<0\> clk gnd vdd) DFF_sync
ends sobel_operator_8bit_reg_schematic

// sobel_operator/shift_reg/schematic
subckt shift_reg BL\<7\> BL\<6\> BL\<5\> BL\<4\> BL\<3\> BL\<2\> BL\<1\> BL\<0\> BM\<7\> BM\<6\> BM\<5\> BM\<4\> BM\<3\> BM\<2\> BM\<1\> BM\<0\> BR\<7\> BR\<6\> BR\<5\> BR\<4\> BR\<3\> BR\<2\> BR\<1\> BR\<0\> ML\<7\> ML\<6\> ML\<5\> ML\<4\> ML\<3\> ML\<2\> ML\<1\> ML\<0\> MR\<7\> MR\<6\> MR\<5\> MR\<4\> MR\<3\> MR\<2\> MR\<1\> MR\<0\> TL\<7\> TL\<6\> TL\<5\> TL\<4\> TL\<3\> TL\<2\> TL\<1\> TL\<0\> TM\<7\> TM\<6\> TM\<5\> TM\<4\> TM\<3\> TM\<2\> TM\<1\> TM\<0\> TR\<7\> TR\<6\> TR\<5\> TR\<4\> TR\<3\> TR\<2\> TR\<1\> TR\<0\> bot_L\<7\> bot_L\<6\> bot_L\<5\> bot_L\<4\> bot_L\<3\> bot_L\<2\> bot_L\<1\> bot_L\<0\> clk gnd mid_L\<7\> mid_L\<6\> mid_L\<5\> mid_L\<4\> mid_L\<3\> mid_L\<2\> mid_L\<1\> mid_L\<0\> up_L\<7\> up_L\<6\> up_L\<5\> up_L\<4\> up_L\<3\> up_L\<2\> up_L\<1\> up_L\<0\> vdd
    I18 (ML\<7\> ML\<6\> ML\<5\> ML\<4\> ML\<3\> ML\<2\> ML\<1\> ML\<0\> net025\<0\> net025\<1\> net025\<2\> net025\<3\> net025\<4\> net025\<5\> net025\<6\> net025\<7\> net029\<0\> net029\<1\> net029\<2\> net029\<3\> net029\<4\> net029\<5\> net029\<6\> net029\<7\> clk gnd vdd) sobel_operator_8bit_reg_schematic
    I11 (TL\<7\> TL\<6\> TL\<5\> TL\<4\> TL\<3\> TL\<2\> TL\<1\> TL\<0\> TM\<7\> TM\<6\> TM\<5\> TM\<4\> TM\<3\> TM\<2\> TM\<1\> TM\<0\> net34\<0\> net34\<1\> net34\<2\> net34\<3\> net34\<4\> net34\<5\> net34\<6\> net34\<7\> clk gnd vdd) sobel_operator_8bit_reg_schematic
    I10 (mid_L\<7\> mid_L\<6\> mid_L\<5\> mid_L\<4\> mid_L\<3\> mid_L\<2\> mid_L\<1\> mid_L\<0\> ML\<7\> ML\<6\> ML\<5\> ML\<4\> ML\<3\> ML\<2\> ML\<1\> ML\<0\> net35\<0\> net35\<1\> net35\<2\> net35\<3\> net35\<4\> net35\<5\> net35\<6\> net35\<7\> clk gnd vdd) sobel_operator_8bit_reg_schematic
    I9 (up_L\<7\> up_L\<6\> up_L\<5\> up_L\<4\> up_L\<3\> up_L\<2\> up_L\<1\> up_L\<0\> TL\<7\> TL\<6\> TL\<5\> TL\<4\> TL\<3\> TL\<2\> TL\<1\> TL\<0\> net56\<0\> net56\<1\> net56\<2\> net56\<3\> net56\<4\> net56\<5\> net56\<6\> net56\<7\> clk gnd vdd) sobel_operator_8bit_reg_schematic
    I13 (TM\<7\> TM\<6\> TM\<5\> TM\<4\> TM\<3\> TM\<2\> TM\<1\> TM\<0\> TR\<7\> TR\<6\> TR\<5\> TR\<4\> TR\<3\> TR\<2\> TR\<1\> TR\<0\> net33\<0\> net33\<1\> net33\<2\> net33\<3\> net33\<4\> net33\<5\> net33\<6\> net33\<7\> clk gnd vdd) sobel_operator_8bit_reg_schematic
    I14 (net025\<0\> net025\<1\> net025\<2\> net025\<3\> net025\<4\> net025\<5\> net025\<6\> net025\<7\> MR\<7\> MR\<6\> MR\<5\> MR\<4\> MR\<3\> MR\<2\> MR\<1\> MR\<0\> net32\<0\> net32\<1\> net32\<2\> net32\<3\> net32\<4\> net32\<5\> net32\<6\> net32\<7\> clk gnd vdd) sobel_operator_8bit_reg_schematic
    I17 (BM\<7\> BM\<6\> BM\<5\> BM\<4\> BM\<3\> BM\<2\> BM\<1\> BM\<0\> BR\<7\> BR\<6\> BR\<5\> BR\<4\> BR\<3\> BR\<2\> BR\<1\> BR\<0\> net29\<0\> net29\<1\> net29\<2\> net29\<3\> net29\<4\> net29\<5\> net29\<6\> net29\<7\> clk gnd vdd) sobel_operator_8bit_reg_schematic
    I16 (BL\<7\> BL\<6\> BL\<5\> BL\<4\> BL\<3\> BL\<2\> BL\<1\> BL\<0\> BM\<7\> BM\<6\> BM\<5\> BM\<4\> BM\<3\> BM\<2\> BM\<1\> BM\<0\> net30\<0\> net30\<1\> net30\<2\> net30\<3\> net30\<4\> net30\<5\> net30\<6\> net30\<7\> clk gnd vdd) sobel_operator_8bit_reg_schematic
    I15 (bot_L\<7\> bot_L\<6\> bot_L\<5\> bot_L\<4\> bot_L\<3\> bot_L\<2\> bot_L\<1\> bot_L\<0\> BL\<7\> BL\<6\> BL\<5\> BL\<4\> BL\<3\> BL\<2\> BL\<1\> BL\<0\> net31\<0\> net31\<1\> net31\<2\> net31\<3\> net31\<4\> net31\<5\> net31\<6\> net31\<7\> clk gnd vdd) sobel_operator_8bit_reg_schematic
ends shift_reg

// sobel_operator/sample_data_input/schematic
subckt sample_data_input bottom\<7\> bottom\<6\> bottom\<5\> bottom\<4\> bottom\<3\> bottom\<2\> bottom\<1\> bottom\<0\> middle\<7\> middle\<6\> middle\<5\> middle\<4\> middle\<3\> middle\<2\> middle\<1\> middle\<0\> top\<7\> top\<6\> top\<5\> top\<4\> top\<3\> top\<2\> top\<1\> top\<0\>
    V23 (bottom\<7\> 0) vsource val1=1.1 val0=0 delay=0 rise=10p fall=10p period=10n type=bit data="0001000100010000" rptstart=1 rpttimes=0
    V22 (bottom\<6\> 0) vsource val1=1.1 val0=0 delay=0 rise=10p fall=10p period=10n type=bit data="0001000100010000" rptstart=1 rpttimes=0
    V21 (bottom\<5\> 0) vsource val1=1.1 val0=0 delay=0 rise=10p fall=10p period=10n type=bit data="0001000100010000" rptstart=1 rpttimes=0
    V20 (bottom\<4\> 0) vsource val1=1.1 val0=0 delay=0 rise=10p fall=10p period=10n type=bit data="0001000100010000" rptstart=1 rpttimes=0
    V19 (bottom\<3\> 0) vsource val1=1.1 val0=0 delay=0 rise=10p fall=10p period=10n type=bit data="0001000100010000" rptstart=1 rpttimes=0
    V18 (bottom\<2\> 0) vsource val1=1.1 val0=0 delay=0 rise=10p fall=10p period=10n type=bit data="0001000100010000" rptstart=1 rpttimes=0
    V17 (bottom\<1\> 0) vsource val1=1.1 val0=0 delay=0 rise=10p fall=10p period=10n type=bit data="0001000100010000" rptstart=1 rpttimes=0
    V16 (bottom\<0\> 0) vsource val1=1.1 val0=0 delay=0 rise=10p fall=10p period=10n type=bit data="0001000100010000" rptstart=1 rpttimes=0
    V15 (middle\<7\> 0) vsource val1=1.1 val0=0 delay=0 rise=10p fall=10p period=10n type=bit data="0001000100010000" rptstart=1 rpttimes=0
    V14 (middle\<6\> 0) vsource val1=1.1 val0=0 delay=0 rise=10p fall=10p period=10n type=bit data="0001000100010000" rptstart=1 rpttimes=0
    V13 (middle\<5\> 0) vsource val1=1.1 val0=0 delay=0 rise=10p fall=10p period=10n type=bit data="0001000100010000" rptstart=1 rpttimes=0
    V12 (middle\<4\> 0) vsource val1=1.1 val0=0 delay=0 rise=10p fall=10p period=10n type=bit data="0001000100010000" rptstart=1 rpttimes=0
    V11 (middle\<3\> 0) vsource val1=1.1 val0=0 delay=0 rise=10p fall=10p period=10n type=bit data="0001000100010000" rptstart=1 rpttimes=0
    V10 (middle\<2\> 0) vsource val1=1.1 val0=0 delay=0 rise=10p fall=10p period=10n type=bit data="0001000100010000" rptstart=1 rpttimes=0
    V9 (middle\<1\> 0) vsource val1=1.1 val0=0 delay=0 rise=10p fall=10p period=10n type=bit data="0001000100010000" rptstart=1 rpttimes=0
    V8 (middle\<0\> 0) vsource val1=1.1 val0=0 delay=0 rise=10p fall=10p period=10n type=bit data="0001000100010000" rptstart=1 rpttimes=0
    V7 (top\<7\> 0) vsource val1=1.1 val0=0 delay=0 rise=10p fall=10p period=10n type=bit data="0001000100010000" rptstart=1 rpttimes=0
    V6 (top\<6\> 0) vsource val1=1.1 val0=0 delay=0 rise=10p fall=10p period=10n type=bit data="0001000100010000" rptstart=1 rpttimes=0
    V5 (top\<5\> 0) vsource val1=1.1 val0=0 delay=0 rise=10p fall=10p period=10n type=bit data="0001000100010000" rptstart=1 rpttimes=0
    V4 (top\<4\> 0) vsource val1=1.1 val0=0 delay=0 rise=10p fall=10p period=10n type=bit data="0001000100010000" rptstart=1 rpttimes=0
    V3 (top\<3\> 0) vsource val1=1.1 val0=0 delay=0 rise=10p fall=10p period=10n type=bit data="0001000100010000" rptstart=1 rpttimes=0
    V2 (top\<2\> 0) vsource val1=1.1 val0=0 delay=0 rise=10p fall=10p period=10n type=bit data="0001000100010000" rptstart=1 rpttimes=0
    V1 (top\<1\> 0) vsource val1=1.1 val0=0 delay=0 rise=10p fall=10p period=10n type=bit data="0001000100010000" rptstart=1 rpttimes=0
    V0 (top\<0\> 0) vsource val1=1.1 val0=0 delay=0 rise=10p fall=10p period=10n type=bit data="0001000100010000" rptstart=1 rpttimes=0
ends sample_data_input

// sobel_operator/clock/schematic
subckt clock clk
    V0 (clk 0) vsource dc=0 type=pulse val0=0 val1=1.1 period=10n delay=1n rise=20p fall=20p width=5n
ends clock

// sobel_operator/test_shift_reg/schematic
I0 (BL\<7\> BL\<6\> BL\<5\> BL\<4\> BL\<3\> BL\<2\> BL\<1\> BL\<0\> BM\<7\> BM\<6\> BM\<5\> BM\<4\> BM\<3\> BM\<2\> BM\<1\> BM\<0\> BR\<7\> BR\<6\> BR\<5\> BR\<4\> BR\<3\> BR\<2\> BR\<1\> BR\<0\> ML\<7\> ML\<6\> ML\<5\> ML\<4\> ML\<3\> ML\<2\> ML\<1\> ML\<0\> MR\<7\> MR\<6\> MR\<5\> MR\<4\> MR\<3\> MR\<2\> MR\<1\> MR\<0\> TL\<7\> TL\<6\> TL\<5\> TL\<4\> TL\<3\> TL\<2\> TL\<1\> TL\<0\> TM\<7\> TM\<6\> TM\<5\> TM\<4\> TM\<3\> TM\<2\> TM\<1\> TM\<0\> TR\<7\> TR\<6\> TR\<5\> TR\<4\> TR\<3\> TR\<2\> TR\<1\> TR\<0\> net6\<0\> net6\<1\> net6\<2\> net6\<3\> net6\<4\> net6\<5\> net6\<6\> net6\<7\> clk net7 net5\<0\> net5\<1\> net5\<2\> net5\<3\> net5\<4\> net5\<5\> net5\<6\> net5\<7\> net4\<0\> net4\<1\> net4\<2\> net4\<3\> net4\<4\> net4\<5\> net4\<6\> net4\<7\> net8) shift_reg
I2 (net6\<0\> net6\<1\> net6\<2\> net6\<3\> net6\<4\> net6\<5\> net6\<6\> net6\<7\> net5\<0\> net5\<1\> net5\<2\> net5\<3\> net5\<4\> net5\<5\> net5\<6\> net5\<7\> net4\<0\> net4\<1\> net4\<2\> net4\<3\> net4\<4\> net4\<5\> net4\<6\> net4\<7\>) sample_data_input
I4 (clk) clock
V1 (net8 0) vsource dc=vdd type=dc
V0 (net7 0) vsource dc=0 type=dc
simulatorOptions options temp=27
tran tran stop=150n errpreset=moderate
save I2.V1:p I2.V1:p TR\<7\> TR\<6\> TR\<5\> TR\<4\> TR\<3\> TR\<2\> TR\<1\> TR\<0\> TM\<7\> TM\<6\> TM\<5\> TM\<4\> TM\<3\> TM\<2\> TM\<1\> TM\<0\> TL\<7\> TL\<6\> TL\<5\> TL\<4\> TL\<3\> TL\<2\> TL\<1\> TL\<0\> MR\<7\> MR\<6\> MR\<5\> MR\<4\> MR\<3\> MR\<2\> MR\<1\> MR\<0\> ML\<7\> ML\<6\> ML\<5\> ML\<4\> ML\<3\> ML\<2\> ML\<1\> ML\<0\> BR\<7\> BR\<6\> BR\<5\> BR\<4\> BR\<3\> BR\<2\> BR\<1\> BR\<0\> BM\<7\> BM\<6\> BM\<5\> BM\<4\> BM\<3\> BM\<2\> BM\<1\> BM\<0\> BL\<7\> BL\<6\> BL\<5\> BL\<4\> BL\<3\> BL\<2\> BL\<1\> BL\<0\> clk
