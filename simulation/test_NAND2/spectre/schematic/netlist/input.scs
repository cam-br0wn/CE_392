// Design: sobel_operator/test_NAND2
simulator lang=spectre
global 0
include "/vol/eecs391/FreePDK45/ncsu_basekit/models/hspice/hspice_nom.include"

// sobel_operator/NAND2/schematic
subckt NAND2 A B Y gnd vdd
    M2 (Y A net16 gnd) NMOS_VTG w=400n l=50n ld=105n ls=105n m=1
    M3 (net16 B gnd gnd) NMOS_VTG w=400n l=50n ld=105n ls=105n m=1
    M0 (Y A vdd vdd) PMOS_VTG w=600n l=50n ld=105n ls=105n m=1
    M1 (Y B vdd vdd) PMOS_VTG w=600n l=50n ld=105n ls=105n m=1
ends NAND2

// sobel_operator/test_NAND2/schematic
I0 (A B Y net7 net6) NAND2
V1 (B 0) vsource val1=1.1 val0=0 delay=10p rise=5p fall=5p period=10n type=bit data="0101" rptstart=1 rpttimes=0
V0 (A 0) vsource val1=1.1 val0=0 delay=10p rise=5p fall=5p period=10n type=bit data="0011" rptstart=1 rpttimes=0
V3 (net7 0) vsource dc=0 type=dc
V2 (net6 0) vsource dc=1.1 type=dc
simulatorOptions options temp=27
tran tran stop=50n errpreset=moderate
save B A Y
